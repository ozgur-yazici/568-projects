# Ansys Electronics Desktop project, version 2019.3
materials:
  vacuum: permittivity=1
  steel_1008: permeability{HUnit=A_per_meter BUnit=tesla curve (0, 0) (159.2, 0.2402) (318.3, 0.8654) (477.5, 1.1106) (636.6, 1.2458) (795.8, 1.331) (1591.5, 1.5) (3183.1, 1.6) (4774.6, 1.683) (6366.2, 1.741) (7957.7, 1.78) (15915.5, 1.905) (31831, 2.025) (47746.5, 2.085) (63662, 2.13) (79577.5, 2.165) (159155, 2.28) (318310, 2.485) (397887, 2.5851)} conductivity=2000000
  NdFe42_up: permittivity=1 permeability=1.1306089 conductivity=625000 magnetic_coercivity{Magnitude=-915000A_per_meter DirComp1=0 DirComp2=1 DirComp3=0} lande_g_factor=2
  NdFe42_down: permittivity=1 permeability=1.1306089 conductivity=625000 magnetic_coercivity{Magnitude=-915000A_per_meter DirComp1=0 DirComp2=-1 DirComp3=0} lande_g_factor=2
  NdFe42_right: permittivity=1 permeability=1.1306089 conductivity=625000 magnetic_coercivity{Magnitude=-915000A_per_meter DirComp1=1 DirComp2=0 DirComp3=0} lande_g_factor=2
  NdFe42_left: permittivity=1 permeability=1.1306089 conductivity=625000 magnetic_coercivity{Magnitude=-915000A_per_meter DirComp1=-1 DirComp2=0 DirComp3=0} lande_g_factor=2

design MaxCir1 (Maxwell Circuit)
components:
  IDC_2 = IDC()
  Res_6 = Res()
  Res_9 = Res()
  Res_12 = Res()
  Res_17 = Res()
  Res_18 = Res()
  IDC_19 = IDC()
  Res_22 = Res()
  Res_25 = Res()
  Res_28 = Res()
nets:
  net_1: IDC_2.1, Res_6.1, Res_9.0
  net_2: Res_17.0, Res_18.1, IDC_19.0
  net_3: Res_12.1, Res_9.1
  net_4: Res_17.1, Res_12.0
  net_5: Res_22.0, Res_18.0, IDC_19.1
  net_6: Res_22.1, IDC_2.0, Res_6.0

design Maxwell2DDesign1 (Maxwell 2D, Magnetostatic, XY geometry, model units mm)
geometry:
  rotor_core [steel_1008] = circle(normal=Z, centre=(0mm, 0mm, 0mm), radius=46mm)
  Polyline1 [NdFe42_up] = polyline((0mm, 0mm, 0mm) (50mm, 0mm, 0mm))
  Polyline1.rotate(axis=Z, angle=18deg)
  Polyline1.sweep_around_axis(axis=Z, angle=72deg)
  rotor_core_1 = rotor_core.copy()
  Polyline1.subtract(rotor_core_1)
  Circle1 = circle(normal=Z, centre=(0mm, 0mm, 0mm), radius=51mm)
  Circle2 [steel_1008] = circle(normal=Z, centre=(0mm, 0mm, 0mm), radius=65.192024mm)
  Circle2.subtract(Circle1)
  Polyline1.rotate(axis=Z, angle=36deg)
  Polyline1_1 [NdFe42_right], Polyline1_2 [NdFe42_down], Polyline1_3 [NdFe42_left] = Polyline1.duplicate_around_axis(axis=Z, angle=90deg, total=4)
  gap_measure = polyline(z=0mm, xy in mm: (-50.5, 0) (3.0922332e-15, 50.5) (50.5, 0), AngularArc from point 0 over 3 centre=(0mm, 0mm, 0mm) angle=-180deg plane=XY)
  gap_measure.rotate(axis=Z, angle=45deg)
  Circle3 [vacuum] = circle(normal=Z, centre=(0mm, 0mm, 0mm), radius=90mm)
  gap_measure1 = polyline(z=0mm, xy in mm: (-50.5, 0) (-35.708892, 35.708892) (3.0922332e-15, 50.5), AngularArc from point 0 over 3 centre=(0mm, 0mm, 0mm) angle=-90deg plane=XY)
  gap_measure1.rotate(axis=Z, angle=45deg)
boundaries and excitations:
  VectorPotential1: Vector Potential Edges=Circle3.edge(1 of 1) Value=0
mesh:
  initial mesh: MeshMethod=AnsoftTAU
setups:
  Setup1: Magnetostatic MaximumPasses=10 MinimumPasses=2 MinimumConvergedPasses=1 PercentRefinement=50 PercentError=1 ConstantDelta=0s NonLinearResidual=0.0001
field calculator expressions:
  nb = B_Vector | 2D_Normal | Dot
field plots:
  Mag_B1: B on Setup1 : LastAdaptive
reports:
  Calculator Expressions Plot 2: nb vs Distance on Setup1 : LastAdaptive; markers m1 at 120.09805mm, m2 at 39.9798mm
  Calculator Expressions Plot 3: nb vs Distance on Setup1 : LastAdaptive
