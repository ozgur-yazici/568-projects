# Ansys Electronics Desktop project, version 2019.3
materials:
  steel_1008: permeability{HUnit=A_per_meter BUnit=tesla curve (0, 0) (159.2, 0.2402) (318.3, 0.8654) (477.5, 1.1106) (636.6, 1.2458) (795.8, 1.331) (1591.5, 1.5) (3183.1, 1.6) (4774.6, 1.683) (6366.2, 1.741) (7957.7, 1.78) (15915.5, 1.905) (31831, 2.025) (47746.5, 2.085) (63662, 2.13) (79577.5, 2.165) (159155, 2.28) (318310, 2.485) (397887, 2.5851)} conductivity=2000000 mass_density=7872
  NdFe35: permittivity=1 permeability=1.0997785 conductivity=625000 magnetic_coercivity{Magnitude=-890000A_per_meter DirComp1=1 DirComp2=0 DirComp3=0} lande_g_factor=2 mass_density=7400
  vacuum: permittivity=1
  steel_1008_2DSF0.950: permeability{HUnit=A_per_meter BUnit=tesla curve (0, 0) (159.2, 0.2282) (318.3, 0.82215) (477.5, 1.0551) (636.6, 1.18355) (795.8, 1.2645) (1591.5, 1.4251) (3183.1, 1.5202) (4774.6, 1.59915) (6366.2, 1.65435) (7957.7, 1.6915) (15915.5, 1.81075) (31831, 1.92575) (47746.5, 1.98375) (63662, 2.0275) (79577.5, 2.06175) (159155, 2.176) (318310, 2.38075) (397887, 2.48084) (1193660, 3.48179)} conductivity=2000000 mass_density=7478.4
  NdFe35_2DSF1.000_N: CoordinateSystemType=Cylindrical permeability=1.09978 conductivity=625000 magnetic_coercivity{Magnitude=-890000A_per_meter DirComp1=1 DirComp2=0 DirComp3=0} mass_density=7400
  NdFe35_2DSF1.000_S: CoordinateSystemType=Cylindrical permeability=1.09978 conductivity=625000 magnetic_coercivity{Magnitude=-890000A_per_meter DirComp1=-1 DirComp2=0 DirComp3=0} mass_density=7400
  copper: permeability=0.999991 conductivity=58000000 mass_density=8933

design Maxwell2DDesign1 (Maxwell 2D, Transient, XY geometry, model units mm)
options: ComputeTransientInductance ModelDepth=60mm Multiplier=fractions
variables:
  fractions = 4
geometry:
  Band [vacuum] = user_primitive(RMxprt/Band, DiaGap=99mm, DiaYoke=70mm, Length=0mm, SegAngle=0deg, Fractions=1, HalfAxial=0, InfoCore=0)
  Shaft [vacuum] = user_primitive(RMxprt/Band, DiaGap=99mm, DiaYoke=70mm, Length=0mm, SegAngle=0deg, Fractions=1, HalfAxial=0, InfoCore=100)
  OuterRegion [vacuum] = user_primitive(RMxprt/Band, DiaGap=99mm, DiaYoke=160mm, Length=0mm, SegAngle=0deg, Fractions=fractions, HalfAxial=0, InfoCore=100)
  Tool = user_primitive(RMxprt/Band, DiaGap=99mm, DiaYoke=160mm, Length=0mm, SegAngle=0deg, Fractions=fractions, HalfAxial=0, InfoCore=1)
  Stator [steel_1008_2DSF0.950] = user_primitive(RMxprt/SlotCore, DiaGap=100mm, DiaYoke=160mm, Length=0mm, Skew=0deg, Slots=24, SlotType=3, Hs0=3mm, Hs01=0mm, Hs1=2mm, Hs2=15mm, Bs0=3mm, Bs1=8.4240753mm, Bs2=12.37365mm, Rs=2mm, FilletType=0, HalfSlot=0, SegAngle=15deg, LenRegion=0mm, InfoCore=0)
  Coil_0 [copper] = user_primitive(RMxprt/LapCoil, DiaGap=100mm, DiaYoke=160mm, Length=0mm, Skew=0deg, Slots=24, SlotType=3, Hs0=3mm, Hs1=2mm, Hs2=15mm, Bs0=3mm, Bs1=8.4240753mm, Bs2=12.37365mm, Rs=2mm, FilletType=0, Layers=2, CoilPitch=1, EndExt=0mm, SpanExt=0mm, BendAngle=0deg, SegAngle=10deg, LenRegion=0mm, InfoCoil=2)
  Coil_1..Coil_5 [copper], Coil_6..Coil_23 = Coil_0.duplicate_around_axis(axis=Z, angle=15deg, total=24)
  Coil_0.unite(Coil_6, Coil_12, Coil_18)
  Coil_1.unite(Coil_7, Coil_13, Coil_19)
  Coil_2.unite(Coil_8, Coil_14, Coil_20)
  Coil_3.unite(Coil_9, Coil_15, Coil_21)
  Coil_4.unite(Coil_10, Coil_16, Coil_22)
  Coil_5.unite(Coil_11, Coil_17, Coil_23)
  CoilRe_0 [copper] = user_primitive(RMxprt/LapCoil, DiaGap=100mm, DiaYoke=160mm, Length=0mm, Skew=0deg, Slots=24, SlotType=3, Hs0=3mm, Hs1=2mm, Hs2=15mm, Bs0=3mm, Bs1=8.4240753mm, Bs2=12.37365mm, Rs=2mm, FilletType=0, Layers=2, CoilPitch=1, EndExt=0mm, SpanExt=0mm, BendAngle=0deg, SegAngle=10deg, LenRegion=0mm, InfoCoil=3)
  CoilRe_0.rotate(axis=Z, angle=-15deg)
  CoilRe_1..CoilRe_5 [copper], CoilRe_6..CoilRe_23 = CoilRe_0.duplicate_around_axis(axis=Z, angle=15deg, total=24)
  CoilRe_0.unite(CoilRe_6, CoilRe_12, CoilRe_18)
  CoilRe_1.unite(CoilRe_7, CoilRe_13, CoilRe_19)
  CoilRe_2.unite(CoilRe_8, CoilRe_14, CoilRe_20)
  CoilRe_3.unite(CoilRe_9, CoilRe_15, CoilRe_21)
  CoilRe_4.unite(CoilRe_10, CoilRe_16, CoilRe_22)
  CoilRe_5.unite(CoilRe_11, CoilRe_17, CoilRe_23)
  Rotor [steel_1008_2DSF0.950] = user_primitive(RMxprt/PMCore, DiaGap=98mm, DiaYoke=70mm, Length=0mm, Poles=20, PoleType=1, Embrace=0.7, ThickMag=4mm, WidthMag=0mm, Offset=0mm, Bridge=0mm, Rib=0mm, LenRegion=0mm, InfoCore=0)
  Mag_0 [NdFe35_2DSF1.000_N] = user_primitive(RMxprt/PMCore, DiaGap=98mm, DiaYoke=70mm, Length=0mm, Poles=20, PoleType=1, Embrace=0.7, ThickMag=4mm, WidthMag=0mm, Offset=0mm, Bridge=0mm, Rib=0mm, LenRegion=0mm, InfoCore=2)
  Mag_1 [NdFe35_2DSF1.000_S], Mag_2 [NdFe35_2DSF1.000_N], Mag_3 [NdFe35_2DSF1.000_S], Mag_4 [NdFe35_2DSF1.000_N], Mag_5..Mag_19 = Mag_0.duplicate_around_axis(axis=Z, angle=18deg, total=20)
  Mag_0.unite(Mag_5, Mag_10, Mag_15)
  Mag_1.unite(Mag_6, Mag_11, Mag_16)
  Mag_2.unite(Mag_7, Mag_12, Mag_17)
  Mag_3.unite(Mag_8, Mag_13, Mag_18)
  Mag_4.unite(Mag_9, Mag_14, Mag_19)
  InnerRegion [vacuum] = user_primitive(RMxprt/PMCore, DiaGap=98mm, DiaYoke=70mm, Length=0mm, Poles=20, PoleType=1, Embrace=0.7, ThickMag=4mm, WidthMag=0mm, Offset=0mm, Bridge=0mm, Rib=0mm, LenRegion=0mm, InfoCore=100)
  Tool_1 = Tool.copy()
  Band.subtract(Tool_1)
  Tool_2 = Tool.copy()
  InnerRegion.subtract(Tool_2)
  Tool_3 = Tool.copy()
  Shaft.subtract(Tool_3)
  Tool_4 = Tool.copy()
  Stator.subtract(Tool_4)
  Tool_5 = Tool.copy()
  Coil_0.subtract(Tool_5)
  Tool_6 = Tool.copy()
  Coil_1.subtract(Tool_6)
  Tool_7 = Tool.copy()
  Coil_2.subtract(Tool_7)
  Tool_8 = Tool.copy()
  Coil_3.subtract(Tool_8)
  Tool_9 = Tool.copy()
  Coil_4.subtract(Tool_9)
  Tool_10 = Tool.copy()
  Coil_5.subtract(Tool_10)
  Tool_11 = Tool.copy()
  CoilRe_0.subtract(Tool_11)
  Tool_12 = Tool.copy()
  CoilRe_1.subtract(Tool_12)
  Tool_13 = Tool.copy()
  CoilRe_2.subtract(Tool_13)
  Tool_14 = Tool.copy()
  CoilRe_3.subtract(Tool_14)
  Tool_15 = Tool.copy()
  CoilRe_4.subtract(Tool_15)
  Tool_16 = Tool.copy()
  CoilRe_5.subtract(Tool_16)
  Tool_17 = Tool.copy()
  Rotor.subtract(Tool_17)
  Tool_18 = Tool.copy()
  Mag_0.subtract(Tool_18)
  Tool_19 = Tool.copy()
  Mag_1.subtract(Tool_19)
  Tool_20 = Tool.copy()
  Mag_2.subtract(Tool_20)
  Tool_21 = Tool.copy()
  Mag_3.subtract(Tool_21)
  Mag_4.subtract(Tool)
  Polyline1 [non-model] = polyline(z=0mm, xy in mm: (49.6, 0) (35.072496, 35.072496) (3.0371241e-15, 49.6), AngularArc from point 0 over 3 centre=(0mm, 0mm, 0mm) angle=90deg plane=XY)
motion:
  MotionSetup1: Band Move_Type=Rotate Coordinate_System=Global Axis=Z Is_Positive=true InitPos=7.5deg Angular_Velocity=1222.14rpm Objects=Band
  Moving1: Moving Objects=[Shaft, Rotor, Mag_0..Mag_4, InnerRegion]
boundaries and excitations:
  VectorPotential1: Vector Potential Edges=OuterRegion.edge(at (56.5685, 56.5685, 0)) Value=0
  Master1: Master Edges=OuterRegion.edge(at (40, 0, 0))
  Slave1: Slave Edges=OuterRegion.edge(at (0, 40, 0)) ReverseU master=Master1 SameAsMaster=false
  PhA_0: Coil Objects=Coil_0 Conductor_number=3 Winding=PhaseA PolarityType=Positive
  PhARe_0: Coil Objects=CoilRe_1 Conductor_number=3 Winding=PhaseA PolarityType=Negative
  PhB_1: Coil Objects=Coil_1 Conductor_number=3 Winding=PhaseB PolarityType=Positive
  PhBRe_1: Coil Objects=CoilRe_2 Conductor_number=3 Winding=PhaseB PolarityType=Negative
  PhBRe_2: Coil Objects=Coil_2 Conductor_number=3 Winding=PhaseB PolarityType=Negative
  PhB_2: Coil Objects=CoilRe_3 Conductor_number=3 Winding=PhaseB PolarityType=Positive
  PhCRe_3: Coil Objects=Coil_3 Conductor_number=3 Winding=PhaseC PolarityType=Negative
  PhC_3: Coil Objects=CoilRe_4 Conductor_number=3 Winding=PhaseC PolarityType=Positive
  PhC_4: Coil Objects=Coil_4 Conductor_number=3 Winding=PhaseC PolarityType=Positive
  PhCRe_4: Coil Objects=CoilRe_5 Conductor_number=3 Winding=PhaseC PolarityType=Negative
  PhA_5: Coil Objects=Coil_5 Conductor_number=3 Winding=PhaseA PolarityType=Positive
  PhA_23: Coil Objects=CoilRe_0 Conductor_number=3 Winding=PhaseA PolarityType=Positive
  PhaseA: Winding Group Type=External IsSolid=false Current=0A ParallelBranchesNum=1
  PhaseB: Winding Group Type=External IsSolid=false Current=0A ParallelBranchesNum=1
  PhaseC: Winding Group Type=External IsSolid=false Current=0A ParallelBranchesNum=1
  external circuit: "* Design: MaxCir1"
mesh:
  SurfApprox_Mag: SurfApproxBased Objects=[Mag_0..Mag_4] CurvedSurfaceApproxChoice=ManualSettings SurfDev=0.049mm NormalDev=15deg
  SurfApprox_Main: SurfApproxBased Objects=[Stator, Rotor, Band, OuterRegion, InnerRegion, Shaft] CurvedSurfaceApproxChoice=ManualSettings SurfDev=0.08mm NormalDev=15deg
  initial mesh: MeshMethod=AnsoftTAU
setups:
  Setup1: Transient NonlinearSolverResidual=0.0001 StopTime=0.01s TimeStep=5e-05s SaveFieldsType="Every N Steps" N_Steps=1 Steps_From=0s Steps_To=0.01s NumberSolveSteps=1 RangeStart=0s RangeEnd=0.1s InitialTimeStep=0.002s MinTimeStep=0.001s MaxTimeStep=0.003s TimeStepErrTolerance=0.0001
output variables:
  pos = (Moving1.Position -7.5 * PI/180) * 10 + PI
  cos0 = cos(pos)
  cos1 = cos(pos-2*PI/3)
  cos2 = cos(pos-4*PI/3)
  sin0 = sin(pos)
  sin1 = sin(pos-2*PI/3)
  sin2 = sin(pos-4*PI/3)
  Lad = L(PhaseA,PhaseA)*cos0 + L(PhaseA,PhaseB)*cos1 + L(PhaseA,PhaseC)*cos2
  Laq = L(PhaseA,PhaseA)*sin0 + L(PhaseA,PhaseB)*sin1 + L(PhaseA,PhaseC)*sin2
  Lbd = L(PhaseB,PhaseA)*cos0 + L(PhaseB,PhaseB)*cos1 + L(PhaseB,PhaseC)*cos2
  Lbq = L(PhaseB,PhaseA)*sin0 + L(PhaseB,PhaseB)*sin1 + L(PhaseB,PhaseC)*sin2
  Lcd = L(PhaseC,PhaseA)*cos0 + L(PhaseC,PhaseB)*cos1 + L(PhaseC,PhaseC)*cos2
  Lcq = L(PhaseC,PhaseA)*sin0 + L(PhaseC,PhaseB)*sin1 + L(PhaseC,PhaseC)*sin2
  L_d = (Lad*cos0 + Lbd*cos1 + Lcd*cos2) * 2/3
  L_q = (Laq*sin0 + Lbq*sin1 + Lcq*sin2) * 2/3
  Flux_d = (FluxLinkage(PhaseA)*cos0+FluxLinkage(PhaseB)*cos1+FluxLinkage(PhaseC)*cos2)*2/3
  Flux_q = (FluxLinkage(PhaseA)*sin0+FluxLinkage(PhaseB)*sin1+FluxLinkage(PhaseC)*sin2)*2/3
  I_d = (Current(PhaseA)*cos0 + Current(PhaseB)*cos1 + Current(PhaseC)*cos2)*2/3
  I_q = (Current(PhaseA)*sin0 + Current(PhaseB)*sin1 + Current(PhaseC)*sin2)*2/3
  Irms = sqrt(I_d^2+I_q^2)/sqrt(2)
  Pcu = 3*Irms^2*0
field calculator expressions:
  nb = B_Vector | 2D_Normal | Dot
field plots:
  Mag_B1: B over Band, Shaft, OuterRegion, Stator, Coil_0..Coil_5, CoilRe_0..CoilRe_5, Rotor, Mag_0..Mag_4, InnerRegion on Setup1 : Transient at Time=0s
reports:
  Torque: Moving1.Torque vs Time on Setup1 : Transient
  Currents: Current(PhaseA), Current(PhaseB), Current(PhaseC) vs Time on Setup1 : Transient
  Induced Voltages: InducedVoltage(PhaseA), InducedVoltage(PhaseB), InducedVoltage(PhaseC) vs Time on Setup1 : Transient
  Flux Linkages: FluxLinkage(PhaseA), FluxLinkage(PhaseB), FluxLinkage(PhaseC) vs Time on Setup1 : Transient
  L_dq: L_d, L_q vs Time on Setup1 : Transient
  Flux_dq: Flux_d, Flux_q vs Time on Setup1 : Transient
  I_dq: I_d, I_q vs Time on Setup1 : Transient
  Calculator Expressions Plot 1: nb vs Distance on Setup1 : Transient [Time=0.01s]

design MaxCir1 (Maxwell Circuit)
variables:
  Kle = 1
components:
  Winding_14 = Winding(Name=PhaseA)
  Winding_21 = Winding(Name=PhaseB)
  Winding_28 = Winding(Name=PhaseC)
  Res_35 = Res(Name=A R=0.024076ohm)
  Res_42 = Res(Name=B R=0.024076ohm)
  Res_49 = Res(Name=C R=0.024076ohm)
  Ind_56 = Ind(Name=A L=2.66647e-07H*Kle)
  Ind_63 = Ind(Name=B L=2.66647e-07H*Kle)
  Ind_70 = Ind(Name=C L=2.66647e-07H*Kle)
  Ammeter_77 = Ammeter(Name=IA)
  Ammeter_84 = Ammeter(Name=IB)
  Ammeter_91 = Ammeter(Name=IC)
  VPulse_98 = VPulse(V1=-1 Td=3 Tr=0 Tf=0 Pw=12 Period=36 Type=POS)
  VPulse_105 = VPulse(V1=-1 Td=9 Tr=0 Tf=0 Pw=12 Period=36 Type=POS)
  VPulse_112 = VPulse(V1=-1 Td=15 Tr=0 Tf=0 Pw=12 Period=36 Type=POS)
  VPulse_119 = VPulse(V1=-1 Td=21 Tr=0 Tf=0 Pw=12 Period=36 Type=POS)
  VPulse_126 = VPulse(V1=-1 Td=27 Tr=0 Tf=0 Pw=12 Period=36 Type=POS)
  VPulse_133 = VPulse(V1=-1 Td=33 Tr=0 Tf=0 Pw=12 Period=36 Type=POS)
  Res_140 = Res()
  Res_147 = Res()
  Res_154 = Res()
  Res_161 = Res()
  Res_168 = Res()
  Res_175 = Res()
  VoltmeterG_182 = VoltmeterG(Name=Vc1)
  VoltmeterG_189 = VoltmeterG(Name=Vc2)
  VoltmeterG_196 = VoltmeterG(Name=Vc3)
  VoltmeterG_203 = VoltmeterG(Name=Vc4)
  VoltmeterG_210 = VoltmeterG(Name=Vc5)
  VoltmeterG_217 = VoltmeterG(Name=Vc6)
  VDC_224 = VDC(V=14V)
  VDC_231 = VDC(V=14V)
  DIODE_238 = DIODE(MOD=DModel1)
  DIODE_245 = DIODE(MOD=DModel1)
  DIODE_252 = DIODE(MOD=DModel1)
  DIODE_259 = DIODE(MOD=DModel1)
  DIODE_266 = DIODE(MOD=DModel1)
  DIODE_273 = DIODE(MOD=DModel1)
  DIODE_280 = DIODE(MOD=DModel1)
  DIODE_287 = DIODE(MOD=DModel1)
  DIODE_294 = DIODE(MOD=DModel1)
  DIODE_301 = DIODE(MOD=DModel1)
  DIODE_308 = DIODE(MOD=DModel1)
  DIODE_315 = DIODE(MOD=DModel1)
  SW_V_322 = SW_V(ID_V=IVc1 MOD=SModel1)
  SW_V_329 = SW_V(ID_V=IVc4 MOD=SModel1)
  SW_V_336 = SW_V(ID_V=IVc3 MOD=SModel1)
  SW_V_343 = SW_V(ID_V=IVc6 MOD=SModel1)
  SW_V_350 = SW_V(ID_V=IVc5 MOD=SModel1)
  SW_V_357 = SW_V(ID_V=IVc2 MOD=SModel1)
  DIODE_Model_364 = DIODE_Model(IS=0.002585A DeviceName=DModel1)
  SW_VModel_371 = SW_VModel(Von=0V Voff=0V DeviceName=SModel1)
nets:
  0: VPulse_98.1, VPulse_105.1, VPulse_112.1, VPulse_119.1, VPulse_126.1, VPulse_133.1, VDC_224.1, VDC_231.0
  net_1: Winding_21.1, Winding_14.1, Winding_28.1
  net_10: Ind_56.0, Ammeter_77.1
  net_11: Ind_63.0, Ammeter_84.1
  net_12: Ind_70.0, Ammeter_91.1
  net_19: VPulse_98.0, Res_140.0, VoltmeterG_182.0
  net_20: VPulse_105.0, Res_147.0, VoltmeterG_189.0
  net_21: VPulse_112.0, Res_154.0, VoltmeterG_196.0
  net_22: VPulse_119.0, Res_161.0, VoltmeterG_203.0
  net_23: VPulse_126.0, Res_168.0, VoltmeterG_210.0
  net_24: VPulse_133.0, Res_175.0, VoltmeterG_217.0
  net_25: Res_140.1, Res_147.1, Res_154.1, Res_161.1, Res_168.1, Res_175.1
  net_31: VDC_224.0, DIODE_245.1, DIODE_259.1, DIODE_273.1, DIODE_280.0, DIODE_294.0, DIODE_308.0
  net_33: VDC_231.1, DIODE_238.0, DIODE_252.0, DIODE_266.0, SW_V_329.1, SW_V_343.1, SW_V_357.1
  net_34: Ammeter_77.0, DIODE_238.1, DIODE_245.0, DIODE_287.0, SW_V_322.1
  net_35: Ammeter_84.0, DIODE_252.1, DIODE_259.0, DIODE_301.0, SW_V_336.1
  net_36: Ammeter_91.0, DIODE_266.1, DIODE_273.0, DIODE_315.0, SW_V_350.1
  net_4: Winding_14.0, Res_35.1
  net_40: DIODE_280.1, SW_V_322.0
  net_41: DIODE_287.1, SW_V_329.0
  net_42: DIODE_294.1, SW_V_336.0
  net_43: DIODE_301.1, SW_V_343.0
  net_44: DIODE_308.1, SW_V_350.0
  net_45: DIODE_315.1, SW_V_357.0
  net_5: Winding_21.0, Res_42.1
  net_6: Winding_28.0, Res_49.1
  net_7: Res_35.0, Ind_56.1
  net_8: Res_42.0, Ind_63.1
  net_9: Res_49.0, Ind_70.1

design RMxprtDesign1 (RMxprt, Brushless Permanent-Magnet DC Motor, model units mm)
machine:
  Machine: FrictionLoss=0W WindLoss=0W ReferenceSpeed=1500rpm NumberOfPoles=20 RotorPosition=true ControlType=0 CircuitType=Y3
  Circuit: TriggerPulseWidth=120deg TransistorDrop=0V DiodeDrop=0V LeadAngleOfTrigger=0deg MaximumCurrent=0A MinimumCurrent=0A
  Stator: SkewWidth=0 NumberOfSlots=24 LaminationSectors=0 PressBoardThickness=0mm OuterDiameter=160mm InnerDiameter=100mm Length=60mm StackingFactor=0.95 SteelType=steel_1008 SlotType=3
  Rotor: OuterDiameter=98mm InnerDiameter=70mm Length=60mm SteelType=steel_1008 PoleType=1 StackingFactor=0.95
  Shaft:
  Stator Slot: Hs0=3mm Hs1=2mm Hs2=15mm Bs0=3mm Bs1=0mm Bs2=0mm Rs=2mm ParallelTooth ToothWidth=6mm
  Stator Winding: WindingType=Whole-Coiled WindingLayers=2 ParallelBranches=1 ConductorsPerSlot=6 CoilPitch=1 EndAdjustment=0mm BaseInnerRadius=0mm TipInnerDiameter=0mm EndClearance=0mm CoilWrap=0mm SlotLiner=0mm WedgeThickness=0mm LayerInsulation=0mm BottomInsulation=0mm LimitedFillFactor=0.75 WdgNumberofPriodicMultipler=1 NumberOfStrands=1 WireWrap=0mm InterturnInsulation=0mm WireDiameter=2mm WireWidth=0mm WireThickness=0mm Gauge=0
  Rotor Pole: Embrace=0.7 Offset=0mm ShaftDiameter=0mm Bridge=0mm Rib=0mm MagnetThickness=4mm MagnetWidth=0mm MagnetType=NdFe35
setups:
  Setup1: BLDC Motor RatedOutputPower=200W RatedVoltage=28V RatedSpeed=1500rpm OperatingTemperature=75cel LoadType=ConstPower

design Maxwell2DDesign2 (Maxwell 2D, Transient, XY geometry, model units mm)
options: ComputeTransientInductance ModelDepth=60mm Multiplier=fractions
variables:
  fractions = 4
geometry:
  Band [vacuum] = user_primitive(RMxprt/Band, DiaGap=99mm, DiaYoke=70mm, Length=0mm, SegAngle=0deg, Fractions=1, HalfAxial=0, InfoCore=0)
  Shaft [vacuum] = user_primitive(RMxprt/Band, DiaGap=99mm, DiaYoke=70mm, Length=0mm, SegAngle=0deg, Fractions=1, HalfAxial=0, InfoCore=100)
  OuterRegion [vacuum] = user_primitive(RMxprt/Band, DiaGap=99mm, DiaYoke=160mm, Length=0mm, SegAngle=0deg, Fractions=fractions, HalfAxial=0, InfoCore=100)
  Tool = user_primitive(RMxprt/Band, DiaGap=99mm, DiaYoke=160mm, Length=0mm, SegAngle=0deg, Fractions=fractions, HalfAxial=0, InfoCore=1)
  Stator [steel_1008_2DSF0.950] = user_primitive(RMxprt/SlotCore, DiaGap=100mm, DiaYoke=160mm, Length=0mm, Skew=0deg, Slots=24, SlotType=3, Hs0=3mm, Hs01=0mm, Hs1=2mm, Hs2=15mm, Bs0=3mm, Bs1=8.4240753mm, Bs2=12.37365mm, Rs=2mm, FilletType=0, HalfSlot=0, SegAngle=15deg, LenRegion=0mm, InfoCore=0)
  Coil_0 [copper] = user_primitive(RMxprt/LapCoil, DiaGap=100mm, DiaYoke=160mm, Length=0mm, Skew=0deg, Slots=24, SlotType=3, Hs0=3mm, Hs1=2mm, Hs2=15mm, Bs0=3mm, Bs1=8.4240753mm, Bs2=12.37365mm, Rs=2mm, FilletType=0, Layers=2, CoilPitch=1, EndExt=0mm, SpanExt=0mm, BendAngle=0deg, SegAngle=10deg, LenRegion=0mm, InfoCoil=2)
  Coil_1..Coil_5 [copper], Coil_6..Coil_23 = Coil_0.duplicate_around_axis(axis=Z, angle=15deg, total=24)
  Coil_0.unite(Coil_6, Coil_12, Coil_18)
  Coil_1.unite(Coil_7, Coil_13, Coil_19)
  Coil_2.unite(Coil_8, Coil_14, Coil_20)
  Coil_3.unite(Coil_9, Coil_15, Coil_21)
  Coil_4.unite(Coil_10, Coil_16, Coil_22)
  Coil_5.unite(Coil_11, Coil_17, Coil_23)
  CoilRe_0 [copper] = user_primitive(RMxprt/LapCoil, DiaGap=100mm, DiaYoke=160mm, Length=0mm, Skew=0deg, Slots=24, SlotType=3, Hs0=3mm, Hs1=2mm, Hs2=15mm, Bs0=3mm, Bs1=8.4240753mm, Bs2=12.37365mm, Rs=2mm, FilletType=0, Layers=2, CoilPitch=1, EndExt=0mm, SpanExt=0mm, BendAngle=0deg, SegAngle=10deg, LenRegion=0mm, InfoCoil=3)
  CoilRe_0.rotate(axis=Z, angle=-15deg)
  CoilRe_1..CoilRe_5 [copper], CoilRe_6..CoilRe_23 = CoilRe_0.duplicate_around_axis(axis=Z, angle=15deg, total=24)
  CoilRe_0.unite(CoilRe_6, CoilRe_12, CoilRe_18)
  CoilRe_1.unite(CoilRe_7, CoilRe_13, CoilRe_19)
  CoilRe_2.unite(CoilRe_8, CoilRe_14, CoilRe_20)
  CoilRe_3.unite(CoilRe_9, CoilRe_15, CoilRe_21)
  CoilRe_4.unite(CoilRe_10, CoilRe_16, CoilRe_22)
  CoilRe_5.unite(CoilRe_11, CoilRe_17, CoilRe_23)
  Rotor [steel_1008_2DSF0.950] = user_primitive(RMxprt/PMCore, DiaGap=98mm, DiaYoke=70mm, Length=0mm, Poles=20, PoleType=1, Embrace=0.7, ThickMag=4mm, WidthMag=0mm, Offset=0mm, Bridge=0mm, Rib=0mm, LenRegion=0mm, InfoCore=0)
  Mag_0 [NdFe35_2DSF1.000_N] = user_primitive(RMxprt/PMCore, DiaGap=98mm, DiaYoke=70mm, Length=0mm, Poles=20, PoleType=1, Embrace=0.7, ThickMag=4mm, WidthMag=0mm, Offset=0mm, Bridge=0mm, Rib=0mm, LenRegion=0mm, InfoCore=2)
  Mag_1 [NdFe35_2DSF1.000_S], Mag_2 [NdFe35_2DSF1.000_N], Mag_3 [NdFe35_2DSF1.000_S], Mag_4 [NdFe35_2DSF1.000_N], Mag_5..Mag_19 = Mag_0.duplicate_around_axis(axis=Z, angle=18deg, total=20)
  Mag_0.unite(Mag_5, Mag_10, Mag_15)
  Mag_1.unite(Mag_6, Mag_11, Mag_16)
  Mag_2.unite(Mag_7, Mag_12, Mag_17)
  Mag_3.unite(Mag_8, Mag_13, Mag_18)
  Mag_4.unite(Mag_9, Mag_14, Mag_19)
  InnerRegion [vacuum] = user_primitive(RMxprt/PMCore, DiaGap=98mm, DiaYoke=70mm, Length=0mm, Poles=20, PoleType=1, Embrace=0.7, ThickMag=4mm, WidthMag=0mm, Offset=0mm, Bridge=0mm, Rib=0mm, LenRegion=0mm, InfoCore=100)
  Tool_1 = Tool.copy()
  Band.subtract(Tool_1)
  Tool_2 = Tool.copy()
  InnerRegion.subtract(Tool_2)
  Tool_3 = Tool.copy()
  Shaft.subtract(Tool_3)
  Tool_4 = Tool.copy()
  Stator.subtract(Tool_4)
  Tool_5 = Tool.copy()
  Coil_0.subtract(Tool_5)
  Tool_6 = Tool.copy()
  Coil_1.subtract(Tool_6)
  Tool_7 = Tool.copy()
  Coil_2.subtract(Tool_7)
  Tool_8 = Tool.copy()
  Coil_3.subtract(Tool_8)
  Tool_9 = Tool.copy()
  Coil_4.subtract(Tool_9)
  Tool_10 = Tool.copy()
  Coil_5.subtract(Tool_10)
  Tool_11 = Tool.copy()
  CoilRe_0.subtract(Tool_11)
  Tool_12 = Tool.copy()
  CoilRe_1.subtract(Tool_12)
  Tool_13 = Tool.copy()
  CoilRe_2.subtract(Tool_13)
  Tool_14 = Tool.copy()
  CoilRe_3.subtract(Tool_14)
  Tool_15 = Tool.copy()
  CoilRe_4.subtract(Tool_15)
  Tool_16 = Tool.copy()
  CoilRe_5.subtract(Tool_16)
  Tool_17 = Tool.copy()
  Rotor.subtract(Tool_17)
  Tool_18 = Tool.copy()
  Mag_0.subtract(Tool_18)
  Tool_19 = Tool.copy()
  Mag_1.subtract(Tool_19)
  Tool_20 = Tool.copy()
  Mag_2.subtract(Tool_20)
  Tool_21 = Tool.copy()
  Mag_3.subtract(Tool_21)
  Mag_4.subtract(Tool)
  Polyline1 [non-model] = polyline(z=0mm, xy in mm: (49.6, 0) (35.072496, 35.072496) (3.0371241e-15, 49.6), AngularArc from point 0 over 3 centre=(0mm, 0mm, 0mm) angle=90deg plane=XY)
motion:
  MotionSetup1: Band Move_Type=Rotate Coordinate_System=Global Axis=Z Is_Positive=true InitPos=7.5deg Angular_Velocity=1222.14rpm Objects=Band
  Moving1: Moving Objects=[Shaft, Rotor, Mag_0..Mag_4, InnerRegion]
boundaries and excitations:
  VectorPotential1: Vector Potential Edges=OuterRegion.edge(at (56.5685, 56.5685, 0)) Value=0
  Master1: Master Edges=OuterRegion.edge(at (40, 0, 0))
  Slave1: Slave Edges=OuterRegion.edge(at (0, 40, 0)) ReverseU master=Master1 SameAsMaster=false
  PhA_0: Coil Objects=Coil_0 Conductor_number=3 Winding=PhaseA PolarityType=Positive
  PhARe_0: Coil Objects=CoilRe_1 Conductor_number=3 Winding=PhaseA PolarityType=Negative
  PhB_1: Coil Objects=Coil_1 Conductor_number=3 Winding=PhaseB PolarityType=Positive
  PhBRe_1: Coil Objects=CoilRe_2 Conductor_number=3 Winding=PhaseB PolarityType=Negative
  PhBRe_2: Coil Objects=Coil_2 Conductor_number=3 Winding=PhaseB PolarityType=Negative
  PhB_2: Coil Objects=CoilRe_3 Conductor_number=3 Winding=PhaseB PolarityType=Positive
  PhCRe_3: Coil Objects=Coil_3 Conductor_number=3 Winding=PhaseC PolarityType=Negative
  PhC_3: Coil Objects=CoilRe_4 Conductor_number=3 Winding=PhaseC PolarityType=Positive
  PhC_4: Coil Objects=Coil_4 Conductor_number=3 Winding=PhaseC PolarityType=Positive
  PhCRe_4: Coil Objects=CoilRe_5 Conductor_number=3 Winding=PhaseC PolarityType=Negative
  PhA_5: Coil Objects=Coil_5 Conductor_number=3 Winding=PhaseA PolarityType=Positive
  PhA_23: Coil Objects=CoilRe_0 Conductor_number=3 Winding=PhaseA PolarityType=Positive
  PhaseA: Winding Group Type=Current IsSolid=false Current=0A ParallelBranchesNum=1
  PhaseB: Winding Group Type=Current IsSolid=false Current=0A ParallelBranchesNum=1
  PhaseC: Winding Group Type=Current IsSolid=false Current=0A ParallelBranchesNum=1
  external circuit: "* Design: MaxCir1"
mesh:
  SurfApprox_Mag: SurfApproxBased Objects=[Mag_0..Mag_4] CurvedSurfaceApproxChoice=ManualSettings SurfDev=0.049mm NormalDev=15deg
  SurfApprox_Main: SurfApproxBased Objects=[Stator, Rotor, Band, OuterRegion, InnerRegion, Shaft] CurvedSurfaceApproxChoice=ManualSettings SurfDev=0.08mm NormalDev=15deg
  initial mesh: MeshMethod=AnsoftTAU
setups:
  Setup1: Transient NonlinearSolverResidual=0.0001 StopTime=0.01s TimeStep=5e-05s SaveFieldsType="Every N Steps" N_Steps=1 Steps_From=0s Steps_To=0.01s NumberSolveSteps=1 RangeStart=0s RangeEnd=0.1s InitialTimeStep=0.002s MinTimeStep=0.001s MaxTimeStep=0.003s TimeStepErrTolerance=0.0001
output variables:
  pos = (Moving1.Position -7.5 * PI/180) * 10 + PI
  cos0 = cos(pos)
  cos1 = cos(pos-2*PI/3)
  cos2 = cos(pos-4*PI/3)
  sin0 = sin(pos)
  sin1 = sin(pos-2*PI/3)
  sin2 = sin(pos-4*PI/3)
  Lad = L(PhaseA,PhaseA)*cos0 + L(PhaseA,PhaseB)*cos1 + L(PhaseA,PhaseC)*cos2
  Laq = L(PhaseA,PhaseA)*sin0 + L(PhaseA,PhaseB)*sin1 + L(PhaseA,PhaseC)*sin2
  Lbd = L(PhaseB,PhaseA)*cos0 + L(PhaseB,PhaseB)*cos1 + L(PhaseB,PhaseC)*cos2
  Lbq = L(PhaseB,PhaseA)*sin0 + L(PhaseB,PhaseB)*sin1 + L(PhaseB,PhaseC)*sin2
  Lcd = L(PhaseC,PhaseA)*cos0 + L(PhaseC,PhaseB)*cos1 + L(PhaseC,PhaseC)*cos2
  Lcq = L(PhaseC,PhaseA)*sin0 + L(PhaseC,PhaseB)*sin1 + L(PhaseC,PhaseC)*sin2
  L_d = (Lad*cos0 + Lbd*cos1 + Lcd*cos2) * 2/3
  L_q = (Laq*sin0 + Lbq*sin1 + Lcq*sin2) * 2/3
  Flux_d = (FluxLinkage(PhaseA)*cos0+FluxLinkage(PhaseB)*cos1+FluxLinkage(PhaseC)*cos2)*2/3
  Flux_q = (FluxLinkage(PhaseA)*sin0+FluxLinkage(PhaseB)*sin1+FluxLinkage(PhaseC)*sin2)*2/3
  I_d = (Current(PhaseA)*cos0 + Current(PhaseB)*cos1 + Current(PhaseC)*cos2)*2/3
  I_q = (Current(PhaseA)*sin0 + Current(PhaseB)*sin1 + Current(PhaseC)*sin2)*2/3
  Irms = sqrt(I_d^2+I_q^2)/sqrt(2)
  Pcu = 3*Irms^2*0
field calculator expressions:
  nb = B_Vector | 2D_Normal | Dot
field plots:
  Mag_B1: B over Band, Shaft, OuterRegion, Stator, Coil_0..Coil_5, CoilRe_0..CoilRe_5, Rotor, Mag_0..Mag_4, InnerRegion on Setup1 : Transient at Time=-1
reports:
  Torque: Moving1.Torque vs Time on Setup1 : Transient
  Currents: Current(PhaseA), Current(PhaseB), Current(PhaseC) vs Time on Setup1 : Transient
  Induced Voltages: InducedVoltage(PhaseA), InducedVoltage(PhaseB), InducedVoltage(PhaseC) vs Time on Setup1 : Transient
  Flux Linkages: FluxLinkage(PhaseA), FluxLinkage(PhaseB), FluxLinkage(PhaseC) vs Time on Setup1 : Transient
  L_dq: L_d, L_q vs Time on Setup1 : Transient
  Flux_dq: Flux_d, Flux_q vs Time on Setup1 : Transient
  I_dq: I_d, I_q vs Time on Setup1 : Transient
  Calculator Expressions Plot 1: nb vs Distance on Setup1 : Transient [Time=0.01s]
  Induced Voltages_1: InducedVoltage(PhaseA), InducedVoltage(PhaseB), InducedVoltage(PhaseC), InducedVoltage(PhaseA)-InducedVoltage(PhaseB) vs Time on Setup1 : Transient

design Maxwell2DDesign3 (Maxwell 2D, Magnetostatic, XY geometry, model units mm)
variables:
  fractions = 4
geometry:
  Band [vacuum] = user_primitive(RMxprt/Band, DiaGap=99mm, DiaYoke=70mm, Length=0mm, SegAngle=0deg, Fractions=1, HalfAxial=0, InfoCore=0)
  Shaft [vacuum] = user_primitive(RMxprt/Band, DiaGap=99mm, DiaYoke=70mm, Length=0mm, SegAngle=0deg, Fractions=1, HalfAxial=0, InfoCore=100)
  OuterRegion [vacuum] = user_primitive(RMxprt/Band, DiaGap=99mm, DiaYoke=160mm, Length=0mm, SegAngle=0deg, Fractions=fractions, HalfAxial=0, InfoCore=100)
  Tool = user_primitive(RMxprt/Band, DiaGap=99mm, DiaYoke=160mm, Length=0mm, SegAngle=0deg, Fractions=fractions, HalfAxial=0, InfoCore=1)
  Stator [steel_1008_2DSF0.950] = user_primitive(RMxprt/SlotCore, DiaGap=100mm, DiaYoke=160mm, Length=0mm, Skew=0deg, Slots=24, SlotType=3, Hs0=3mm, Hs01=0mm, Hs1=2mm, Hs2=15mm, Bs0=3mm, Bs1=8.4240753mm, Bs2=12.37365mm, Rs=2mm, FilletType=0, HalfSlot=0, SegAngle=15deg, LenRegion=0mm, InfoCore=0)
  Coil_0 [copper] = user_primitive(RMxprt/LapCoil, DiaGap=100mm, DiaYoke=160mm, Length=0mm, Skew=0deg, Slots=24, SlotType=3, Hs0=3mm, Hs1=2mm, Hs2=15mm, Bs0=3mm, Bs1=8.4240753mm, Bs2=12.37365mm, Rs=2mm, FilletType=0, Layers=2, CoilPitch=1, EndExt=0mm, SpanExt=0mm, BendAngle=0deg, SegAngle=10deg, LenRegion=0mm, InfoCoil=2)
  Coil_1..Coil_5 [copper], Coil_6..Coil_23 = Coil_0.duplicate_around_axis(axis=Z, angle=15deg, total=24)
  Coil_0.unite(Coil_6, Coil_12, Coil_18)
  Coil_1.unite(Coil_7, Coil_13, Coil_19)
  Coil_2.unite(Coil_8, Coil_14, Coil_20)
  Coil_3.unite(Coil_9, Coil_15, Coil_21)
  Coil_4.unite(Coil_10, Coil_16, Coil_22)
  Coil_5.unite(Coil_11, Coil_17, Coil_23)
  CoilRe_0 [copper] = user_primitive(RMxprt/LapCoil, DiaGap=100mm, DiaYoke=160mm, Length=0mm, Skew=0deg, Slots=24, SlotType=3, Hs0=3mm, Hs1=2mm, Hs2=15mm, Bs0=3mm, Bs1=8.4240753mm, Bs2=12.37365mm, Rs=2mm, FilletType=0, Layers=2, CoilPitch=1, EndExt=0mm, SpanExt=0mm, BendAngle=0deg, SegAngle=10deg, LenRegion=0mm, InfoCoil=3)
  CoilRe_0.rotate(axis=Z, angle=-15deg)
  CoilRe_1..CoilRe_5 [copper], CoilRe_6..CoilRe_23 = CoilRe_0.duplicate_around_axis(axis=Z, angle=15deg, total=24)
  CoilRe_0.unite(CoilRe_6, CoilRe_12, CoilRe_18)
  CoilRe_1.unite(CoilRe_7, CoilRe_13, CoilRe_19)
  CoilRe_2.unite(CoilRe_8, CoilRe_14, CoilRe_20)
  CoilRe_3.unite(CoilRe_9, CoilRe_15, CoilRe_21)
  CoilRe_4.unite(CoilRe_10, CoilRe_16, CoilRe_22)
  CoilRe_5.unite(CoilRe_11, CoilRe_17, CoilRe_23)
  Rotor [steel_1008_2DSF0.950] = user_primitive(RMxprt/PMCore, DiaGap=98mm, DiaYoke=70mm, Length=0mm, Poles=20, PoleType=1, Embrace=0.7, ThickMag=4mm, WidthMag=0mm, Offset=0mm, Bridge=0mm, Rib=0mm, LenRegion=0mm, InfoCore=0)
  Mag_0 [NdFe35_2DSF1.000_N] = user_primitive(RMxprt/PMCore, DiaGap=98mm, DiaYoke=70mm, Length=0mm, Poles=20, PoleType=1, Embrace=0.7, ThickMag=4mm, WidthMag=0mm, Offset=0mm, Bridge=0mm, Rib=0mm, LenRegion=0mm, InfoCore=2)
  Mag_1 [NdFe35_2DSF1.000_S], Mag_2 [NdFe35_2DSF1.000_N], Mag_3 [NdFe35_2DSF1.000_S], Mag_4 [NdFe35_2DSF1.000_N], Mag_5..Mag_19 = Mag_0.duplicate_around_axis(axis=Z, angle=18deg, total=20)
  Mag_0.unite(Mag_5, Mag_10, Mag_15)
  Mag_1.unite(Mag_6, Mag_11, Mag_16)
  Mag_2.unite(Mag_7, Mag_12, Mag_17)
  Mag_3.unite(Mag_8, Mag_13, Mag_18)
  Mag_4.unite(Mag_9, Mag_14, Mag_19)
  InnerRegion [vacuum] = user_primitive(RMxprt/PMCore, DiaGap=98mm, DiaYoke=70mm, Length=0mm, Poles=20, PoleType=1, Embrace=0.7, ThickMag=4mm, WidthMag=0mm, Offset=0mm, Bridge=0mm, Rib=0mm, LenRegion=0mm, InfoCore=100)
  Tool_1 = Tool.copy()
  Band.subtract(Tool_1)
  Tool_2 = Tool.copy()
  InnerRegion.subtract(Tool_2)
  Tool_3 = Tool.copy()
  Shaft.subtract(Tool_3)
  Tool_4 = Tool.copy()
  Stator.subtract(Tool_4)
  Tool_5 = Tool.copy()
  Coil_0.subtract(Tool_5)
  Tool_6 = Tool.copy()
  Coil_1.subtract(Tool_6)
  Tool_7 = Tool.copy()
  Coil_2.subtract(Tool_7)
  Tool_8 = Tool.copy()
  Coil_3.subtract(Tool_8)
  Tool_9 = Tool.copy()
  Coil_4.subtract(Tool_9)
  Tool_10 = Tool.copy()
  Coil_5.subtract(Tool_10)
  Tool_11 = Tool.copy()
  CoilRe_0.subtract(Tool_11)
  Tool_12 = Tool.copy()
  CoilRe_1.subtract(Tool_12)
  Tool_13 = Tool.copy()
  CoilRe_2.subtract(Tool_13)
  Tool_14 = Tool.copy()
  CoilRe_3.subtract(Tool_14)
  Tool_15 = Tool.copy()
  CoilRe_4.subtract(Tool_15)
  Tool_16 = Tool.copy()
  CoilRe_5.subtract(Tool_16)
  Tool_17 = Tool.copy()
  Rotor.subtract(Tool_17)
  Tool_18 = Tool.copy()
  Mag_0.subtract(Tool_18)
  Tool_19 = Tool.copy()
  Mag_1.subtract(Tool_19)
  Tool_20 = Tool.copy()
  Mag_2.subtract(Tool_20)
  Tool_21 = Tool.copy()
  Mag_3.subtract(Tool_21)
  Mag_4.subtract(Tool)
  Polyline1 [non-model] = polyline(z=0mm, xy in mm: (49.6, 0) (35.072496, 35.072496) (3.0371241e-15, 49.6), AngularArc from point 0 over 3 centre=(0mm, 0mm, 0mm) angle=90deg plane=XY)
boundaries and excitations:
  VectorPotential1: Vector Potential Edges=OuterRegion.edge(at (56.5685, 56.5685, 0)) Value=0
  Master1: Master Edges=OuterRegion.edge(at (40, 0, 0))
  Slave1: Slave Edges=OuterRegion.edge(at (0, 40, 0)) ReverseU master=Master1 SameAsMaster=false
mesh:
  SurfApprox_Mag: SurfApproxBased Objects=[Mag_0..Mag_4] CurvedSurfaceApproxChoice=ManualSettings SurfDev=0.049mm NormalDev=15deg
  SurfApprox_Main: SurfApproxBased Objects=[Stator, Rotor, Band, OuterRegion, InnerRegion, Shaft] CurvedSurfaceApproxChoice=ManualSettings SurfDev=0.08mm NormalDev=15deg
  initial mesh: MeshMethod=AnsoftTAU
setups:
  Setup1: Magnetostatic MaximumPasses=10 MinimumPasses=2 MinimumConvergedPasses=1 PercentRefinement=30 PercentError=0.2 ConstantDelta=0s NonLinearResidual=0.0001
output variables:
  pos = (Moving1.Position -7.5 * PI/180) * 10 + PI
  cos0 = cos(pos)
  cos1 = cos(pos-2*PI/3)
  cos2 = cos(pos-4*PI/3)
  sin0 = sin(pos)
  sin1 = sin(pos-2*PI/3)
  sin2 = sin(pos-4*PI/3)
  Lad = L(PhaseA,PhaseA)*cos0 + L(PhaseA,PhaseB)*cos1 + L(PhaseA,PhaseC)*cos2
  Laq = L(PhaseA,PhaseA)*sin0 + L(PhaseA,PhaseB)*sin1 + L(PhaseA,PhaseC)*sin2
  Lbd = L(PhaseB,PhaseA)*cos0 + L(PhaseB,PhaseB)*cos1 + L(PhaseB,PhaseC)*cos2
  Lbq = L(PhaseB,PhaseA)*sin0 + L(PhaseB,PhaseB)*sin1 + L(PhaseB,PhaseC)*sin2
  Lcd = L(PhaseC,PhaseA)*cos0 + L(PhaseC,PhaseB)*cos1 + L(PhaseC,PhaseC)*cos2
  Lcq = L(PhaseC,PhaseA)*sin0 + L(PhaseC,PhaseB)*sin1 + L(PhaseC,PhaseC)*sin2
  L_d = (Lad*cos0 + Lbd*cos1 + Lcd*cos2) * 2/3
  L_q = (Laq*sin0 + Lbq*sin1 + Lcq*sin2) * 2/3
  Flux_d = (FluxLinkage(PhaseA)*cos0+FluxLinkage(PhaseB)*cos1+FluxLinkage(PhaseC)*cos2)*2/3
  Flux_q = (FluxLinkage(PhaseA)*sin0+FluxLinkage(PhaseB)*sin1+FluxLinkage(PhaseC)*sin2)*2/3
  I_d = (Current(PhaseA)*cos0 + Current(PhaseB)*cos1 + Current(PhaseC)*cos2)*2/3
  I_q = (Current(PhaseA)*sin0 + Current(PhaseB)*sin1 + Current(PhaseC)*sin2)*2/3
  Irms = sqrt(I_d^2+I_q^2)/sqrt(2)
  Pcu = 3*Irms^2*0
field calculator expressions:
  nb = B_Vector | 2D_Normal | Dot
reports:
  Calculator Expressions Plot 1: nb vs Distance on Setup1 : LastAdaptive
